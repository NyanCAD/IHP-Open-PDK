`include "disciplines.vams"

`define sg13g2_lv_nmos_vfbo (((`mc_ok <= 0) || (0.01 <= 0) ? `sg13g2_lv_nmos_vfbo_norm : $rdist_normal(_rdist_seed, `sg13g2_lv_nmos_vfbo_norm, (0.01 * `sg13g2_lv_nmos_vfbo_norm) / `mc_ok)))
`define sg13g2_lv_nmos_toxo (((`mc_ok <= 0) || (0.0133 <= 0) ? `sg13g2_lv_nmos_toxo_norm : $rdist_normal(_rdist_seed, `sg13g2_lv_nmos_toxo_norm, (0.0133 * `sg13g2_lv_nmos_toxo_norm) / `mc_ok)))
`define sg13g2_lv_nmos_dphibo (((`mc_ok <= 0) || (0.0656 <= 0) ? `sg13g2_lv_nmos_dphibo_norm : $rdist_normal(_rdist_seed, `sg13g2_lv_nmos_dphibo_norm, (0.0656 * `sg13g2_lv_nmos_dphibo_norm) / `mc_ok)))
`define sg13g2_lv_nmos_dphibl (((`mc_ok <= 0) || (0.1135 <= 0) ? `sg13g2_lv_nmos_dphibl_norm : $rdist_normal(_rdist_seed, `sg13g2_lv_nmos_dphibl_norm, (0.1135 * `sg13g2_lv_nmos_dphibl_norm) / `mc_ok)))
`define sg13g2_lv_nmos_dphibw (((`mc_ok <= 0) || (0.1197 <= 0) ? `sg13g2_lv_nmos_dphibw_norm : $rdist_normal(_rdist_seed, `sg13g2_lv_nmos_dphibw_norm, (0.1197 * `sg13g2_lv_nmos_dphibw_norm) / `mc_ok)))
`define sg13g2_lv_nmos_dphiblw (((`mc_ok <= 0) || (0.0135 <= 0) ? `sg13g2_lv_nmos_dphiblw_norm : $rdist_normal(_rdist_seed, `sg13g2_lv_nmos_dphiblw_norm, (0.0135 * `sg13g2_lv_nmos_dphiblw_norm) / `mc_ok)))
`define sg13g2_lv_nmos_toxovo (((`mc_ok <= 0) || (0.0133 <= 0) ? `sg13g2_lv_nmos_toxovo_norm : $rdist_normal(_rdist_seed, `sg13g2_lv_nmos_toxovo_norm, (0.0133 * `sg13g2_lv_nmos_toxovo_norm) / `mc_ok)))
`define sg13g2_lv_nmos_ctl (((`mc_ok <= 0) || (0.1562 <= 0) ? `sg13g2_lv_nmos_ctl_norm : $rdist_normal(_rdist_seed, `sg13g2_lv_nmos_ctl_norm, (0.1562 * `sg13g2_lv_nmos_ctl_norm) / `mc_ok)))
`define sg13g2_lv_nmos_muew (((`mc_ok <= 0) || (0.032 <= 0) ? `sg13g2_lv_nmos_muew_norm : $rdist_normal(_rdist_seed, `sg13g2_lv_nmos_muew_norm, (0.032 * `sg13g2_lv_nmos_muew_norm) / `mc_ok)))
`define sg13g2_lv_nmos_themuo (((`mc_ok <= 0) || (0.0026 <= 0) ? `sg13g2_lv_nmos_themuo_norm : $rdist_normal(_rdist_seed, `sg13g2_lv_nmos_themuo_norm, (0.0026 * `sg13g2_lv_nmos_themuo_norm) / `mc_ok)))
`define sg13g2_lv_nmos_rsw1 (((`mc_ok <= 0) || (0.0407 <= 0) ? `sg13g2_lv_nmos_rsw1_norm : $rdist_normal(_rdist_seed, `sg13g2_lv_nmos_rsw1_norm, (0.0407 * `sg13g2_lv_nmos_rsw1_norm) / `mc_ok)))
`define sg13g2_lv_nmos_thesatl (((`mc_ok <= 0) || (0.0908 <= 0) ? `sg13g2_lv_nmos_thesatl_norm : $rdist_normal(_rdist_seed, `sg13g2_lv_nmos_thesatl_norm, (0.0908 * `sg13g2_lv_nmos_thesatl_norm) / `mc_ok)))
`define sg13g2_lv_nmos_thesatw (((`mc_ok <= 0) || (0.0272 <= 0) ? `sg13g2_lv_nmos_thesatw_norm : $rdist_normal(_rdist_seed, `sg13g2_lv_nmos_thesatw_norm, (0.0272 * `sg13g2_lv_nmos_thesatw_norm) / `mc_ok)))
`define sg13g2_lv_nmos_thesatlw (((`mc_ok <= 0) || (0.1503 <= 0) ? `sg13g2_lv_nmos_thesatlw_norm : $rdist_normal(_rdist_seed, `sg13g2_lv_nmos_thesatlw_norm, (0.1503 * `sg13g2_lv_nmos_thesatlw_norm) / `mc_ok)))
`define sg13g2_lv_nmos_cjorbot (((`mc_ok <= 0) || (0.0267 <= 0) ? `sg13g2_lv_nmos_cjorbot_norm : $rdist_normal(_rdist_seed, `sg13g2_lv_nmos_cjorbot_norm, (0.0267 * `sg13g2_lv_nmos_cjorbot_norm) / `mc_ok)))
`define sg13g2_lv_nmos_cjorsti (((`mc_ok <= 0) || (0.0267 <= 0) ? `sg13g2_lv_nmos_cjorsti_norm : $rdist_normal(_rdist_seed, `sg13g2_lv_nmos_cjorsti_norm, (0.0267 * `sg13g2_lv_nmos_cjorsti_norm) / `mc_ok)))
`define sg13g2_lv_nmos_cjorgat (((`mc_ok <= 0) || (0.0267 <= 0) ? `sg13g2_lv_nmos_cjorgat_norm : $rdist_normal(_rdist_seed, `sg13g2_lv_nmos_cjorgat_norm, (0.0267 * `sg13g2_lv_nmos_cjorgat_norm) / `mc_ok)))
`define sg13g2_lv_pmos_vfbo (((`mc_ok <= 0) || (0.01 <= 0) ? `sg13g2_lv_pmos_vfbo_norm : $rdist_normal(_rdist_seed, `sg13g2_lv_pmos_vfbo_norm, (0.01 * `sg13g2_lv_pmos_vfbo_norm) / `mc_ok)))
`define sg13g2_lv_pmos_toxo (((`mc_ok <= 0) || (0.0133 <= 0) ? `sg13g2_lv_pmos_toxo_norm : $rdist_normal(_rdist_seed, `sg13g2_lv_pmos_toxo_norm, (0.0133 * `sg13g2_lv_pmos_toxo_norm) / `mc_ok)))
`define sg13g2_lv_pmos_dphibo (((`mc_ok <= 0) || (0.0656 <= 0) ? `sg13g2_lv_pmos_dphibo_norm : $rdist_normal(_rdist_seed, `sg13g2_lv_pmos_dphibo_norm, (0.0656 * `sg13g2_lv_pmos_dphibo_norm) / `mc_ok)))
`define sg13g2_lv_pmos_dphibl (((`mc_ok <= 0) || (0.1135 <= 0) ? `sg13g2_lv_pmos_dphibl_norm : $rdist_normal(_rdist_seed, `sg13g2_lv_pmos_dphibl_norm, (0.1135 * `sg13g2_lv_pmos_dphibl_norm) / `mc_ok)))
`define sg13g2_lv_pmos_dphibw (((`mc_ok <= 0) || (0.1197 <= 0) ? `sg13g2_lv_pmos_dphibw_norm : $rdist_normal(_rdist_seed, `sg13g2_lv_pmos_dphibw_norm, (0.1197 * `sg13g2_lv_pmos_dphibw_norm) / `mc_ok)))
`define sg13g2_lv_pmos_dphiblw (((`mc_ok <= 0) || (0.0135 <= 0) ? `sg13g2_lv_pmos_dphiblw_norm : $rdist_normal(_rdist_seed, `sg13g2_lv_pmos_dphiblw_norm, (0.0135 * `sg13g2_lv_pmos_dphiblw_norm) / `mc_ok)))
`define sg13g2_lv_pmos_toxovo (((`mc_ok <= 0) || (0.0133 <= 0) ? `sg13g2_lv_pmos_toxovo_norm : $rdist_normal(_rdist_seed, `sg13g2_lv_pmos_toxovo_norm, (0.0133 * `sg13g2_lv_pmos_toxovo_norm) / `mc_ok)))
`define sg13g2_lv_pmos_ctl (((`mc_ok <= 0) || (0.1562 <= 0) ? `sg13g2_lv_pmos_ctl_norm : $rdist_normal(_rdist_seed, `sg13g2_lv_pmos_ctl_norm, (0.1562 * `sg13g2_lv_pmos_ctl_norm) / `mc_ok)))
`define sg13g2_lv_pmos_muew (((`mc_ok <= 0) || (0.032 <= 0) ? `sg13g2_lv_pmos_muew_norm : $rdist_normal(_rdist_seed, `sg13g2_lv_pmos_muew_norm, (0.032 * `sg13g2_lv_pmos_muew_norm) / `mc_ok)))
`define sg13g2_lv_pmos_themuo (((`mc_ok <= 0) || (0.0026 <= 0) ? `sg13g2_lv_pmos_themuo_norm : $rdist_normal(_rdist_seed, `sg13g2_lv_pmos_themuo_norm, (0.0026 * `sg13g2_lv_pmos_themuo_norm) / `mc_ok)))
`define sg13g2_lv_pmos_rsw1 (((`mc_ok <= 0) || (0.0407 <= 0) ? `sg13g2_lv_pmos_rsw1_norm : $rdist_normal(_rdist_seed, `sg13g2_lv_pmos_rsw1_norm, (0.0407 * `sg13g2_lv_pmos_rsw1_norm) / `mc_ok)))
`define sg13g2_lv_pmos_thesatl (((`mc_ok <= 0) || (0.0908 <= 0) ? `sg13g2_lv_pmos_thesatl_norm : $rdist_normal(_rdist_seed, `sg13g2_lv_pmos_thesatl_norm, (0.0908 * `sg13g2_lv_pmos_thesatl_norm) / `mc_ok)))
`define sg13g2_lv_pmos_thesatw (((`mc_ok <= 0) || (0.0272 <= 0) ? `sg13g2_lv_pmos_thesatw_norm : $rdist_normal(_rdist_seed, `sg13g2_lv_pmos_thesatw_norm, (0.0272 * `sg13g2_lv_pmos_thesatw_norm) / `mc_ok)))
`define sg13g2_lv_pmos_thesatlw (((`mc_ok <= 0) || (0.1503 <= 0) ? `sg13g2_lv_pmos_thesatlw_norm : $rdist_normal(_rdist_seed, `sg13g2_lv_pmos_thesatlw_norm, (0.1503 * `sg13g2_lv_pmos_thesatlw_norm) / `mc_ok)))
`define sg13g2_lv_pmos_cjorbot (((`mc_ok <= 0) || (0.0267 <= 0) ? `sg13g2_lv_pmos_cjorbot_norm : $rdist_normal(_rdist_seed, `sg13g2_lv_pmos_cjorbot_norm, (0.0267 * `sg13g2_lv_pmos_cjorbot_norm) / `mc_ok)))
`define sg13g2_lv_pmos_cjorsti (((`mc_ok <= 0) || (0.0267 <= 0) ? `sg13g2_lv_pmos_cjorsti_norm : $rdist_normal(_rdist_seed, `sg13g2_lv_pmos_cjorsti_norm, (0.0267 * `sg13g2_lv_pmos_cjorsti_norm) / `mc_ok)))
`define sg13g2_lv_pmos_cjorgat (((`mc_ok <= 0) || (0.0267 <= 0) ? `sg13g2_lv_pmos_cjorgat_norm : $rdist_normal(_rdist_seed, `sg13g2_lv_pmos_cjorgat_norm, (0.0267 * `sg13g2_lv_pmos_cjorgat_norm) / `mc_ok)))
