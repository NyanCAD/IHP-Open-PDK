`include "disciplines.vams"

`define cap_carea (((`mc_ok <= 0) || (0.033 <= 0) ? `cap_carea_norm : $rdist_normal(_rdist_seed, `cap_carea_norm, (0.033 * `cap_carea_norm) / `mc_ok)))
`define cap_cpara (((`mc_ok <= 0) || (0.067 <= 0) ? `cap_cpara_norm : $rdist_normal(_rdist_seed, `cap_cpara_norm, (0.067 * `cap_cpara_norm) / `mc_ok)))
