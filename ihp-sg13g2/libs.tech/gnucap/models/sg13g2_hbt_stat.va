`include "disciplines.vams"

`define vbic_cje (((`mc_ok <= 0) || (0.058 <= 0) ? `vbic_cje_norm : $rdist_normal(_rdist_seed, `vbic_cje_norm, (0.058 * `vbic_cje_norm) / `mc_ok)))
`define vbic_cjc (((`mc_ok <= 0) || (0.043 <= 0) ? `vbic_cjc_norm : $rdist_normal(_rdist_seed, `vbic_cjc_norm, (0.043 * `vbic_cjc_norm) / `mc_ok)))
`define vbic_cjcp (((`mc_ok <= 0) || (0.037 <= 0) ? `vbic_cjcp_norm : $rdist_normal(_rdist_seed, `vbic_cjcp_norm, (0.037 * `vbic_cjcp_norm) / `mc_ok)))
`define vbic_is (((`mc_ok <= 0) || (0.087 <= 0) ? `vbic_is_norm : $rdist_normal(_rdist_seed, `vbic_is_norm, (0.087 * `vbic_is_norm) / `mc_ok)))
`define vbic_ibei (((`mc_ok <= 0) || (0.11 <= 0) ? `vbic_ibei_norm : $rdist_normal(_rdist_seed, `vbic_ibei_norm, (0.11 * `vbic_ibei_norm) / `mc_ok)))
`define vbic_re (((`mc_ok <= 0) || (0.09 <= 0) ? `vbic_re_norm : $rdist_normal(_rdist_seed, `vbic_re_norm, (0.09 * `vbic_re_norm) / `mc_ok)))
`define vbic_rcx (((`mc_ok <= 0) || (0.069 <= 0) ? `vbic_rcx_norm : $rdist_normal(_rdist_seed, `vbic_rcx_norm, (0.069 * `vbic_rcx_norm) / `mc_ok)))
`define vbic_rbx (((`mc_ok <= 0) || (0.041 <= 0) ? `vbic_rbx_norm : $rdist_normal(_rdist_seed, `vbic_rbx_norm, (0.041 * `vbic_rbx_norm) / `mc_ok)))
`define sgp_mpa_cje (((`mc_ok <= 0) || (0.015 <= 0) ? `sgp_mpa_cje_norm : $rdist_normal(_rdist_seed, `sgp_mpa_cje_norm, (0.015 * `sgp_mpa_cje_norm) / `mc_ok)))
`define sgp_mpa_cjc (((`mc_ok <= 0) || (0.007 <= 0) ? `sgp_mpa_cjc_norm : $rdist_normal(_rdist_seed, `sgp_mpa_cjc_norm, (0.007 * `sgp_mpa_cjc_norm) / `mc_ok)))
`define sgp_mpa_is (((`mc_ok <= 0) || (0.043 <= 0) ? `sgp_mpa_is_norm : $rdist_normal(_rdist_seed, `sgp_mpa_is_norm, (0.043 * `sgp_mpa_is_norm) / `mc_ok)))
`define sgp_mpa_bf (((`mc_ok <= 0) || (0.079 <= 0) ? `sgp_mpa_bf_norm : $rdist_normal(_rdist_seed, `sgp_mpa_bf_norm, (0.079 * `sgp_mpa_bf_norm) / `mc_ok)))
`define sgp_mpa_re (((`mc_ok <= 0) || (0.016 <= 0) ? `sgp_mpa_re_norm : $rdist_normal(_rdist_seed, `sgp_mpa_re_norm, (0.016 * `sgp_mpa_re_norm) / `mc_ok)))
`define sgp_mpa_rb (((`mc_ok <= 0) || (0.008 <= 0) ? `sgp_mpa_rb_norm : $rdist_normal(_rdist_seed, `sgp_mpa_rb_norm, (0.008 * `sgp_mpa_rb_norm) / `mc_ok)))
`define sgp_mpa_rc (((`mc_ok <= 0) || (0.017 <= 0) ? `sgp_mpa_rc_norm : $rdist_normal(_rdist_seed, `sgp_mpa_rc_norm, (0.017 * `sgp_mpa_rc_norm) / `mc_ok)))
